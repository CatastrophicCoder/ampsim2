* harness testbench "b1" -- GENERATED by harness/testbench_gen.py, do not edit
* source: reference/spice/jcm800_2203.cir (sha256 5b0b8095ad124450)
* B1 InputStageV1a. Input: guitar source at node in. Output: p1a (open).
* Supply bpA: constant from F op.
.include tubes.lib
.param vol=0.6 treble=0.5 middle=0.5 bass=0.5 master=0.3 presence=0.5
.param rv1=4k vnl=505 rsrc=100
.func atap(x) {max((pwr(81,x)-1)/80,1e-4)}
.func ltap(x) {max(min(x,0.9999),1e-4)}
.param lpt=25 npr={sqrt(1700/16)}

*** B1 (from the reference netlist)
Vin in 0 DC 0 AC 1
R2 in 0 1Meg
R3 in g1a 68k
X1a p1a g1a k1a 12AX7
R1 k1a 0 2.7k
C1 k1a 0 0.68u
R4 bpA p1a 100k

*** supply (inserted by the harness)
Vsup_bpA bpA 0 DC 390.287888

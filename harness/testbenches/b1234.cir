* harness testbench "b1234" -- GENERATED by harness/testbench_gen.py, do not edit
* source: reference/spice/jcm800_2203.cir (sha256 7bea8385e4adb04e)
* B1234 Preamp: B12, B3 and B4 in one tree with an 8-port root (no J2 / J3; DECISIONS D-038).
* Input: guitar source at node in. Output: y (open, master wiper). Supplies bpA, bpX: constant
* from F op (the cascade study drives them with F's recorded waveforms).
.include tubes.lib
.param vol=0.6 treble=0.5 middle=0.5 bass=0.5 master=0.3 presence=0.5
.param rv1=4k vnl=505 rsrc=100
.func atap(x) {max((pwr(81,x)-1)/80,1e-4)}
.func ltap(x) {max(min(x,0.9999),1e-4)}
.param lpt=25.61 npr={sqrt(1700/16)} kot=0.9997925

*** B12 (from the reference netlist)
Vin in 0 DC 0 AC 1
R2 in 0 1Meg
R3 in g1a 68k
X1a p1a g1a k1a 12AX7
R1 k1a 0 2.7k
C1 k1a 0 0.68u
R4 bpA p1a 100k
C3 p1a nA 0.022u
R5 nA vtop 470k
C4 nA vtop 470p
C5 vtop w1 1n
RVR1a vtop w1 {1Meg*(1-atap(vol))+1}
RVR1b w1 0 {1Meg*atap(vol)+1}
X1b p1b w1 k1b 12AX7
R6 k1b 0 10k
R7 bpA p1b 100k

*** B3 (from the reference netlist)
C7 p1b nB 0.022u
R10 nB g2a 470k
C8 nB g2a 470p
R11 g2a 0 470k
X2a p2a g2a k2a 12AX7
R9 k2a 0 820
R12 bpX p2a 100k
X2b bpX p2a k2b 12AX7
R13 k2b 0 100k

*** B4 (from the reference netlist)
C10 k2b tt 470p
R15 k2b nD 33k
C11 nD nE 0.022u
C12 nD mw 0.022u
RVR3a tt tw {220k*(1-ltap(treble))}
RVR3b tw nE {220k*ltap(treble)}
RVR5 nE nbb {1Meg*atap(bass)+1}
RVR4a nbb mw {22k*(1-ltap(middle))}
RVR4b mw 0 {22k*ltap(middle)}
RVR2a tw y {1Meg*(1-atap(master))+1}
RVR2b y 0 {1Meg*atap(master)+1}

*** supply (inserted by the harness)
Vsup_bpA bpA 0 DC 391.921506
Vsup_bpX bpX 0 DC 404.998185

* harness testbench "b2" -- GENERATED by harness/testbench_gen.py, do not edit
* source: reference/spice/jcm800_2203.cir (sha256 5b0b8095ad124450)
* B2 StageV1b. Input: J1 Thevenin source (v_oc(p1a), R_th1) into node p1a.
* Output: p1b (open). Supply bpA: constant from F op.
* PENDING: R_th for j1 not measured yet (M0 step 5); placeholder 1 ohm
.include tubes.lib
.param vol=0.6 treble=0.5 middle=0.5 bass=0.5 master=0.3 presence=0.5
.param rv1=4k vnl=505 rsrc=100
.func atap(x) {max((pwr(81,x)-1)/80,1e-4)}
.func ltap(x) {max(min(x,0.9999),1e-4)}
.param lpt=25 npr={sqrt(1700/16)}
.param rth_j1=1

*** B2 (from the reference netlist)
C3 p1a nA 0.022u
R5 nA vtop 470k
C4 nA vtop 470p
C5 vtop w1 1n
RVR1a vtop w1 {1Meg*(1-atap(vol))+1}
RVR1b w1 0 {1Meg*atap(vol)+1}
X1b p1b w1 k1b 12AX7
R6 k1b 0 10k
R7 bpA p1b 100k

*** J1 (inserted by the harness)
Vin j1s 0 DC 297.104229 AC 1
Rth_j1 j1s p1a {rth_j1}

*** supply (inserted by the harness)
Vsup_bpA bpA 0 DC 390.287888

* harness testbench "b3" -- GENERATED by harness/testbench_gen.py, do not edit
* source: reference/spice/jcm800_2203.cir (sha256 644058cfd9d89e17)
* B3 StageV2aV2b. Input: J2 Thevenin source (v_oc(p1b), R_th2) into node p1b.
* Output: k2b (open). Supply bpX: constant from F op.
.include tubes.lib
.param vol=0.6 treble=0.5 middle=0.5 bass=0.5 master=0.3 presence=0.5
.param rv1=4k vnl=505 rsrc=100
.func atap(x) {max((pwr(81,x)-1)/80,1e-4)}
.func ltap(x) {max(min(x,0.9999),1e-4)}
.param lpt=25.61 npr={sqrt(1700/16)} kot=0.9997925
.param rth_j2=89731.8

*** B3 (from the reference netlist)
C7 p1b nB 0.022u
R10 nB g2a 470k
C8 nB g2a 470p
R11 g2a 0 470k
X2a p2a g2a k2a 12AX7
R9 k2a 0 820
R12 bpX p2a 100k
X2b bpX p2a k2b 12AX7
R13 k2b 0 100k

*** J2 (inserted by the harness)
Vin j2s 0 DC 353.278252 AC 1
Rth_j2 j2s p1b {rth_j2}

*** supply (inserted by the harness)
Vsup_bpX bpX 0 DC 403.307219

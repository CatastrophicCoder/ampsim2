* harness testbench "b34" -- GENERATED by harness/testbench_gen.py, do not edit
* source: reference/spice/jcm800_2203.cir (sha256 7bea8385e4adb04e)
* B34 StageV2aV2bToneStack: B3 and B4 joined in one tree (no J3; DECISIONS D-033).
* Input: J2 Thevenin source (v_oc(p1b), R_th2) into node p1b. Output: y (open, master wiper).
* Supply bpX: constant from F op.
.include tubes.lib
.param vol=0.6 treble=0.5 middle=0.5 bass=0.5 master=0.3 presence=0.5
.param rv1=4k vnl=505 rsrc=100
.func atap(x) {max((pwr(81,x)-1)/80,1e-4)}
.func ltap(x) {max(min(x,0.9999),1e-4)}
.param lpt=25.61 npr={sqrt(1700/16)} kot=0.9997925
.param rth_j2=89732.8

*** B3 (from the reference netlist)
C7 p1b nB 0.022u
R10 nB g2a 470k
C8 nB g2a 470p
R11 g2a 0 470k
X2a p2a g2a k2a 12AX7
R9 k2a 0 820
R12 bpX p2a 100k
X2b bpX p2a k2b 12AX7
R13 k2b 0 100k

*** B4 (from the reference netlist)
C10 k2b tt 470p
R15 k2b nD 33k
C11 nD nE 0.022u
C12 nD mw 0.022u
RVR3a tt tw {220k*(1-ltap(treble))}
RVR3b tw nE {220k*ltap(treble)}
RVR5 nE nbb {1Meg*atap(bass)+1}
RVR4a nbb mw {22k*(1-ltap(middle))}
RVR4b mw 0 {22k*ltap(middle)}
RVR2a tw y {1Meg*(1-atap(master))+1}
RVR2b y 0 {1Meg*atap(master)+1}

*** J2 (inserted by the harness)
Vin j2s 0 DC 354.750235 AC 1
Rth_j2 j2s p1b {rth_j2}

*** supply (inserted by the harness)
Vsup_bpX bpX 0 DC 404.998185

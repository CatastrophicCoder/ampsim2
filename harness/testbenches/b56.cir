* harness testbench "b56" -- GENERATED by harness/testbench_gen.py, do not edit
* source: reference/spice/jcm800_2203.cir (sha256 7bea8385e4adb04e)
* B56+B7: phase inverter, power stage and supply with instantaneous NFB (VERIFICATION §1).
* Input: J4 Thevenin source (v_oc(y), R_th4) into node y; R_th4 = DC formula (WDF_DESIGN §6).
* Preamp loads on bpA / bpX: constant current sinks from F op (recorded waveforms in M4).
.include tubes.lib
.param vol=0.6 treble=0.5 middle=0.5 bass=0.5 master=0.3 presence=0.5
.param rv1=4k vnl=505 rsrc=100
.func atap(x) {max((pwr(81,x)-1)/80,1e-4)}
.func ltap(x) {max(min(x,0.9999),1e-4)}
.param lpt=25.61 npr={sqrt(1700/16)} kot=0.9997925

*** B5 (from the reference netlist)
C9 y g3a 0.022u
R17 g3a nF 1Meg
R16 k3 nF 470
R19 nF g3b 1Meg
C15 g3b nG 0.1u
R20 nF nG 10k
R23 nG 0 4.7k
C17 nG npr 0.1u
RVR6 npr 0 {22k*(1-ltap(presence))+1}
R22 nG out 100k
X3a p3a g3a k3 12AX7
X3b p3b g3b k3 12AX7
R18 bpX p3a 82k
R21 bpX p3b 100k

*** B6 (from the reference netlist)
C14 p3a nGn 0.022u
C16 p3b nOr 0.022u
C18 nGn nOr 47p
R24 nGn nbias 220k
R25 nbias nOr 220k
C19 nbias 0 10u
Vc20 c20 0 DC -60
R27 c20 nbias 15k
R26 nbias nrv 47k
RRV1 nrv 0 {rv1}
R31 nGn g4 5.6k
R33 nGn g5 5.6k
R32 nOr g6 5.6k
R34 nOr g7 5.6k
R35 s4 nScr 1k
R37 s5 nScr 1k
R36 s6 nScr 1k
R38 s7 nScr 1k
X4 pA s4 g4 0 EL34
X5 pA s5 g5 0 EL34
X6 pB s6 g6 0 EL34
X7 pB s7 g7 0 EL34
Lp1 pA1 ct {lpt/4}
Lp2 ct pB1 {lpt/4}
Ls out sl {lpt/(npr*npr)}
Rwp1 pA pA1 15.36
Rwp2 pB1 pB 16.56
Rws sl 0 0.320
K1 Lp1 Lp2 {kot}
K2 Lp1 Ls {kot}
K3 Lp2 Ls {kot}
Rload out 0 16

*** B7 (from the reference netlist)
Vht raw 0 DC {vnl}
Rsrc raw ct {rsrc}
C23 ct 0 50u
Lch ct nch 5
Rch nch nScr 115
C22 nScr 0 50u
R29 nScr bpX 10k
C21b bpX 0 50u
R8 bpX bpA 10k
C21a bpA 0 50u

*** J4 (inserted by the harness)
.param rth_j4={1/(1/(1Meg*atap(master)+1) + 1/((1Meg*(1-atap(master))+1) + 220k*ltap(treble) + (1Meg*atap(bass)+1) + 22k))}
Vin j4s 0 DC 0 AC 1
Rth_j4 j4s y {rth_j4}

*** preamp load (inserted by the harness)
Isink_bpA bpA 0 DC 0.00129863961
Isink_bpX bpX 0 DC 0.0040289243

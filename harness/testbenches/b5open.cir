* harness testbench "b5open" -- GENERATED by harness/testbench_gen.py, do not edit
* source: reference/spice/jcm800_2203.cir (sha256 83f01b6fd8b64a06)
* B5-open: phase inverter with R22 driven by the recorded speaker voltage (ideal source).
* Input: J4 Thevenin source into node y. Outputs: p3a, p3b (open).
* Recorded sources (from a B56 run): out, bpX. DC values from F op.
.include tubes.lib
.param vol=0.6 treble=0.5 middle=0.5 bass=0.5 master=0.3 presence=0.5
.param rv1=4k vnl=505 rsrc=100
.func atap(x) {max((pwr(81,x)-1)/80,1e-4)}
.func ltap(x) {max(min(x,0.9999),1e-4)}
.param lpt=25.61 npr={sqrt(1700/16)} kot=0.9997925

*** B5 (from the reference netlist)
C9 y g3a 0.022u
R17 g3a nF 1Meg
R16 k3 nF 470
R19 nF g3b 1Meg
C15 g3b nG 0.1u
R20 nF nG 10k
R23 nG 0 4.7k
C17 nG npr 0.1u
RVR6 npr 0 {22k*(1-ltap(presence))+1}
R22 nG out 100k
X3a p3a g3a k3 12AX7
X3b p3b g3b k3 12AX7
R18 bpX p3a 82k
R21 bpX p3b 100k

*** J4 (inserted by the harness)
.param rth_j4={1/(1/(1Meg*atap(master)+1) + 1/((1Meg*(1-atap(master))+1) + 220k*ltap(treble) + (1Meg*atap(bass)+1) + 22k))}
Vin j4s 0 DC 0 AC 1
Rth_j4 j4s y {rth_j4}

*** recorded (inserted by the harness)
Vrec_out out 0 DC 4.24088407e-05
Vrec_bpx bpX 0 DC 404.998185

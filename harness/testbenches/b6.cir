* harness testbench "b6" -- GENERATED by harness/testbench_gen.py, do not edit
* source: reference/spice/jcm800_2203.cir (sha256 ffd9b2812204248f)
* B6 PowerStage driven by the recorded PI open-circuit outputs through R_thA / R_thB.
* No Vin: both inputs are recorded sources (from a B56 / B5-open run). Output: out.
* Recorded supply rails (from a B56 run): ct, nScr. DC values from F op.
.include tubes.lib
.param vol=0.6 treble=0.5 middle=0.5 bass=0.5 master=0.3 presence=0.5
.param rv1=4k vnl=505 rsrc=100
.func atap(x) {max((pwr(81,x)-1)/80,1e-4)}
.func ltap(x) {max(min(x,0.9999),1e-4)}
.param lpt=25.61 npr={sqrt(1700/16)} kot=0.9997925
.param rth_j5a=58067.6
.param rth_j5b=56937.4

*** B6 (from the reference netlist)
C14 p3a nGn 0.022u
C16 p3b nOr 0.022u
C18 nGn nOr 47p
R24 nGn nbias 220k
R25 nbias nOr 220k
C19 nbias 0 10u
Vc20 c20 0 DC -60
R27 c20 nbias 15k
R26 nbias nrv 47k
RRV1 nrv 0 {rv1}
R31 nGn g4 5.6k
R33 nGn g5 5.6k
R32 nOr g6 5.6k
R34 nOr g7 5.6k
R35 s4 nScr 1k
R37 s5 nScr 1k
R36 s6 nScr 1k
R38 s7 nScr 1k
X4 pA s4 g4 0 EL34
X5 pA s5 g5 0 EL34
X6 pB s6 g6 0 EL34
X7 pB s7 g7 0 EL34
Lp1 pA1 ct {lpt/4}
Lp2 ct pB1 {lpt/4}
Ls out sl {lpt/(npr*npr)}
Rwp1 pA pA1 15.36
Rwp2 pB1 pB 16.56
Rws sl 0 0.320
K1 Lp1 Lp2 {kot}
K2 Lp1 Ls {kot}
K3 Lp2 Ls {kot}
Rspk_e out spk1 13
Lspk_e spk1 spk2 1.0m
Rspk_le spk1 spk2 45
Rspk_m spk2 0 37
Lspk_m spk2 0 0.0294437
Cspk_m spk2 0 8.60297e-05

*** J5a (inserted by the harness)
Vrec_p3a j5a 0 DC 272.611263
Rth_j5a j5a p3a {rth_j5a}

*** J5b (inserted by the harness)
Vrec_p3b j5b 0 DC 263.951199
Rth_j5b j5b p3b {rth_j5b}

*** recorded (inserted by the harness)
Vrec_ct ct 0 DC 491.346637
Vrec_nscr nScr 0 DC 488.880467
